ADE simulation setup
Test CASS_Competition_opamp3_tb_2: CASS_Competition/opamp3_tb/schematic, simulator spectre
  Models: /home/cadencepc/Documents/Cadence_Workarea/sky130_release_0.0.4/libs/sky130_fd_pr_main/../../models/sky130.lib.spice[tt]
  Temperature: 27
  Analysis dc: (saves the operating point)
  Analysis ac: start=1 stop=10M
Test CASS_Competition_opamp3_tb_1: CASS_Competition/opamp3_tb/schematic, simulator spectre
  Models: /home/cadencepc/Documents/Cadence_Workarea/sky130_release_0.0.4/libs/sky130_fd_pr_main/../../models/sky130.lib.spice[tt]
  Temperature: 27
  Analysis dc: (saves the operating point)
  Analysis ac: start=1 stop=10M
  Output (VF("/net3") / VF("/V0/PLUS"))
  Output phaseMargin(VF("/net3"))
  Output dB20(VF("/net3"))
  Signals: /net3, /V0/PLUS (terminal) as /V0/PLUS_V
Run mode: Single Run, Sweeps and Corners
