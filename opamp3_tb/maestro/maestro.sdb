ADE simulation setup
Run mode: Single Run, Sweeps and Corners
Tests:
  CASS_Competition_opamp3_tb_1: CASS_Competition/opamp3_tb/schematic, simulator spectre
  CASS_Competition_opamp3_tb_2: CASS_Competition/opamp3_tb/schematic, simulator spectre
