ADE simulation setup
Test CASS_Competition_FOPID_1: CASS_Competition/FOPID/schematic, simulator spectre
  Models: /home/cadencepc/Documents/Cadence_Workarea/sky130_release_0.0.4/libs/sky130_fd_pr_main/../../models/sky130.lib.spice[tt]
  Temperature: 27
  Analysis dc: (saves the operating point)
  Analysis tran: stop=500m
Run mode: Single Run, Sweeps and Corners
