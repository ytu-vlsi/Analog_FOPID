ADE simulation setup
Run mode: Single Run, Sweeps and Corners
Tests:
  CASS_Competition_FOPID_1: CASS_Competition/FOPID/schematic, simulator spectre
