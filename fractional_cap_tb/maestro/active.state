ADE simulation setup
Test CASS_Competition_fractional_cap_tb_1: CASS_Competition/fractional_cap_tb/schematic, simulator spectre
  Models: /home/cadencepc/Documents/Cadence_Workarea/sky130_release_0.0.4/libs/sky130_fd_pr_main/../../models/sky130.lib.spice[tt]
  Temperature: 27
  Analysis ac: start=1 stop=10K
  Analysis dc: (saves the operating point)
  Analysis tran: stop=50m
  Output dB20(mag(v("/net2" ?result "ac")))
  Signals: /net2
Run mode: Single Run, Sweeps and Corners
