ADE simulation setup
Run mode: Single Run, Sweeps and Corners
Tests:
  CASS_Competition_fractional_cap_tb_1: CASS_Competition/fractional_cap_tb/schematic, simulator spectre
